** sch_path: /home/wing/Data/EDA/xschem/bridge/ac_test.sch
**.subckt ac_test
R1 net1 0 1k
V1 net1 0 DC 0 AC 1
**** begin user architecture code

.AC dec 1 100 1Meg
.plot ac vdb(r1)

**** end user architecture code
**.ends
.end
